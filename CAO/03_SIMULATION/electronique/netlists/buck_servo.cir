* LMR51430 behavioural peak-current-mode buck - BRC-M400 servo rail
* Datasheet values: fsw 500 kHz, Rds(on) HS 120 mOhm / LS 70 mOhm, Vref 0.600 V, tSS 4 ms
Vin vin 0 24
Cin vin 0 20u
* --- clock (set pulses, also min on-time) and slope compensation ramp
Vclk clk 0 PULSE(0 1 0 2n 2n 40n 2u)
Vramp ramp 0 PULSE(0 0.1 0 1.99u 2n 1n 2u)
* --- soft-start reference 0 -> 0.600 V in 4 ms
Vref ref 0 PWL(0 0 4m 0.6)
* --- error amplifier: PI (Kp = 55, zero 3 kHz) + 100 kHz pole, clamp = current limit ~5 A
* integrator with anti-windup clamp (-0.1 .. 1.2 V)
Be e 0 V = v(ref)-v(fb)
Bint 0 xi I = 1.0368*v(e) * ((v(e) > 0) ? ((v(xi) < 1.2) ? 1 : 0) : ((v(xi) > -0.1) ? 1 : 0))
Cint xi 0 1u
Rint xi 0 1e12
Bvc vcr 0 V = max(0, min(1.05, 55*v(e) + v(xi)))
Rvc vcr vc 1k
Cvc vc 0 1.6n
* --- current sense (Ri = 0.2 V/A) and PWM latch
H1 isns 0 Vimeas 0.2
Bset s 0 V = v(clk) > 0.5 ? 1 : 0
Brst r 0 V = (v(isns) + v(ramp) > v(vc)) ? 1 : 0
Bq q 0 V = v(s) > 0.5 ? 1 : (v(r) > 0.5 ? 0 : (v(qd) > 0.5 ? 1 : 0))
Rqd q qd 10
Cqd qd 0 10p
Bqn qn 0 V = 1 - v(q)
* --- synchronous power stage
S1 vin lx q 0 SWHS
S2 lx 0 qn 0 SWLS
Dbody 0 lx DBODY
.model SWHS SW(Ron=0.12 Roff=1e6 Vt=0.5 Vh=0.05)
.model SWLS SW(Ron=0.07 Roff=1e6 Vt=0.5 Vh=0.05)
.model DBODY D(IS=1e-9 RS=0.05 CJO=200p)
* --- L1 Sunlord SWPA8040S100MT 10 uH (DCR ~ 25 mOhm)
Vimeas lx lx2 0
L1 lx2 lr 10u
RL lr vout 0.025
* --- output caps: 2x22 uF X5R (effective ~30 uF at 6 V) + 100 uF electrolytic
Cc vout cc 30u
Rcc cc 0 2m
Ce vout ce 100u
Rce ce 0 0.08
* --- feedback divider R2/R3 = 100k / 11k
R2 vout fb 100k
R3 fb 0 11k
* --- servo load profile: 0.3 A -> 2.5 A stall at 6 ms -> 0.6 A at 8 ms
Vprof prof 0 PWL(0 0.3 6m 0.3 6.002m 2.5 8m 2.5 8.002m 0.6 10m 0.6)
Bload vout 0 I = v(prof)*min(1, max(0, v(vout)/5))
.options interp
.control
tran 0.25u 10m 0 10n
wrdata data/buck_full.txt v(vout) i(Vimeas) v(prof) i(Vin)
.endc
.end
