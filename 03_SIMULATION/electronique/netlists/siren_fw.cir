* Siren power stage - inductive turn-off
Vvin vin 0 12
Cloc vin 0 22u
Lsir vin sa 1.25m
Rsir sa sirn 12
Dfw sirn vin SS34
M1 sirn g 0 BSC028
Vpwm pwm 0 PULSE(0 3.3 50u 5n 5n 750u 2)
* --- UCC27511A behavioural: 13 ns delay, OUTH 4 A source, OUTL 8 A sink, VDD = +12V_GD (11.96 V, elevateur TPS61040)
Vdd vdd 0 11.96
Cdd vdd 0 1u
Bin inl 0 V = v(pwm) > 1.8 ? 1 : 0
Rdl inl ind 1k
Cdl ind 0 13p
Bnd indn 0 V = 1 - v(ind)
Sh vdd outh ind 0 SWH
Sl outl 0 indn 0 SWL
.model SWH SW(Ron=3.0 Roff=1e8 Vt=0.5 Vh=0.01)
.model SWL SW(Ron=1.5 Roff=1e8 Vt=0.5 Vh=0.01)
Rgh outh g 4.7
Rgl outl g 1
Rgpd g 0 10k
.model BSC028 VDMOS(Rd=0.9m Rs=0.4m Rg=1.0 Vto=1.7 Kp=180 lambda=0.01 Cgs=4.2n Cgdmax=2n Cgdmin=40p A=0.3 Cjo=1.6n M=0.5 Vj=0.8 Is=2e-11 N=1.05 Rb=2m BV=66 IBV=1m TT=20n ksubthres=0.1 mtriode=1.2)
.model SS54 D(IS=5e-5 N=1.1 RS=0.02 CJO=400p BV=40)
.model SS34 D(IS=3e-5 N=1.1 RS=0.04 CJO=250p BV=40)

.options interp
.control
tran 10n 1.3m 0 10n
wrdata data/siren_fw.txt v(sirn) i(Lsir)
.endc
.end
