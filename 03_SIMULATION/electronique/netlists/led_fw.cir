* LED array PWM power stage - BRC-M400
Vvin vin 0 12
Ltr vin vin2 20n
Cloc vin2 0 22u
* LED array 12 V: wiring 1 uH + 0.8 ohm ballast + 9 V string (45 W -> 3.75 A)
Lw vin2 la 1u
Rled la lb 0.8
Dled lb lc DLEDI
Vled lc ledn 9
.model DLEDI D(IS=1e-12 N=0.3)
Dfw ledn vin2 SS54
M1 ledn g src BSC028
Rsh src 0 10m
Vpwm pwm 0 PULSE(0 3.3 5u 5n 5n 25u 50u)
* --- UCC27511A behavioural: 13 ns delay, OUTH 4 A source, OUTL 8 A sink, VDD = +12V_GD (11.96 V, elevateur TPS61040)
Vdd vdd 0 11.96
Cdd vdd 0 1u
Bin inl 0 V = v(pwm) > 1.8 ? 1 : 0
Rdl inl ind 1k
Cdl ind 0 13p
Bnd indn 0 V = 1 - v(ind)
Sh vdd outh ind 0 SWH
Sl outl 0 indn 0 SWL
.model SWH SW(Ron=3.0 Roff=1e8 Vt=0.5 Vh=0.01)
.model SWL SW(Ron=1.5 Roff=1e8 Vt=0.5 Vh=0.01)
Rgh outh g 4.7
Rgl outl g 1
Rgpd g src 10k
.model BSC028 VDMOS(Rd=0.9m Rs=0.4m Rg=1.0 Vto=1.7 Kp=180 lambda=0.01 Cgs=4.2n Cgdmax=2n Cgdmin=40p A=0.3 Cjo=1.6n M=0.5 Vj=0.8 Is=2e-11 N=1.05 Rb=2m BV=66 IBV=1m TT=20n ksubthres=0.1 mtriode=1.2)
.model SS54 D(IS=5e-5 N=1.1 RS=0.02 CJO=400p BV=40)
.model SS34 D(IS=3e-5 N=1.1 RS=0.04 CJO=250p BV=40)

.options interp
.control
tran 0.5n 105u 0 0.5n
wrdata data/led_fw.txt v(g,src) v(ledn) i(Lw) v(src)
.endc
.end
